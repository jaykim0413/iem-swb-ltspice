* SWB rotary line - step 5: contact bounce on close and release
V1 VCC 0 3.3
R1 VCC IN {Rpu}
C1 IN 0 8.5p
S1 IN 0 CTRL 0 SWmodel
.model SWmodel SW(Ron=0.1 Roff=1Meg Vt=1.65 Vh=0.1)
* Closes at 1 ms with ~0.2 ms of bounce, releases at 5 ms with the same
Vctrl CTRL 0 PWL(0 0 1m 0 1.05m 3.3 1.08m 0 1.12m 3.3 1.15m 0 1.2m 3.3
+ 5m 3.3 5.05m 0 5.08m 3.3 5.12m 0 5.15m 3.3 5.2m 0 10m 0)
.step param Rpu list 70k 100k 140k
.tran 0 10m 0 100n
.meas TRAN t_first_low WHEN V(IN)=0.99 FALL=1
.meas TRAN t_settled_low WHEN V(IN)=0.99 FALL=3
.end
