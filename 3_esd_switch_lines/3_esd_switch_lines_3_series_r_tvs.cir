* Test 3 ESD on switch lines - Step 3 series resistor plus TVS
* Plan: ltspice-testing/esd_protection_test_plan.md step 3
* TVS at the CONNECTOR (line node) to GND, series resistor between it and the pin.
*   Order matters: the resistor then pushes the strike current into the TVS and
*   keeps it out of the chip. (Changed 2026-09-28 from the plan's original
*   TVS-at-the-pin placement - see the plan's correction note.)
* The generic TVS (BV 6 V, 10 pF) is a placeholder: swap in the vendor SPICE
*   model once candidates exist, and re-check any thin pass with the vendor's
*   own IEC waveform model.
* Record per step: Vpin_max/min, chip internal clamp currents, TVS peak current.
* Pass: Vpin stays within -0.5 V to 6.5 V, or exceeds it only for well under a
*   nanosecond with small chip clamp current.
* Then carry the chosen Rser and TVS into steps 4 and 5 - protection that breaks
*   normal readings is worse than none.
* ngspice reference (2026-09-28): TVS + 1 kOhm: 9.4 mA into the chip at +8 kV, pin -0.59
*   V at -8 kV. TVS + 100 Ohm: 127 mA. TVS alone: 6.7 A. The pin still touches ~8 V (the
*   placeholder internal clamp) because the generic 0.5 Ohm TVS lets the connector rise to
*   ~18 V; a real TVS model decides this.
* Checked in ngspice by expanding .step; not yet opened in LTSpice.
.model Dclamp D(Is=1e-12 Rs=1)
.model Dint D(Is=1e-12 BV=8 IBV=1m Rs=1)
.model TVSd D(Is=1e-12 BV=6 IBV=1m Rs=0.5 Cjo=10p)
.model SWe SW(Ron=0.01 Roff=1e12 Vt=0.5 Vh=0)
Cs hv 0 150p IC={Vesd}
Sd hv x ctl 0 SWe
Vctl ctl 0 PULSE(0 1 1n 0.1n 0.1n 1 2)
Rd x line 330
Vst line pt 0
Dtvs 0 pt TVSd
Rs line pin {Rser}
Cpin pin 0 8.5p
* Chip pin model. P-port pins are IOFF-protected (datasheet: +-1 uA at 3.6 V with
* VCC = 0), so there is NO clamp diode from the pin up to VCC. Positive strikes
* go into an internal ESD clamp to GND (Dint, trigger ~8 V PLACEHOLDER - not
* published); negative strikes go into the clamp diode to GND (Ddn).
Vsu pin pu 0
Dint 0 pu Dint
Vsd nd pin 0
Ddn 0 nd Dclamp
Rpu VCC pin 100k
Vcc VCC 0 3.3
.ic V(pin)=3.3 V(line)=3.3 V(pt)=3.3
.step param Rser list 1m 100 1k
.step param Vesd list 8k -8k
.tran 10p 100n 0 50p uic
.meas TRAN Vpin_max MAX V(pin)
.meas TRAN Vpin_min MIN V(pin)
.meas TRAN Iint_max MAX I(Vsu)
.meas TRAN Idn_max MAX I(Vsd)
.meas TRAN Itvs_max MAX I(Vst)
.meas TRAN Itvs_min MIN I(Vst)
.end
