* Test 1 wheel supply - Step 5 ride-through of a QD contact interruption
* Plan: ltspice-testing/wheel_3v3_supply_test_plan.md step 6
* The QD supply contact opens at 10 ms for Tdrop, then closes again.
* Loads are resistors (3.3 V / Ild) so the rail stops drawing when it empties.
* Record per step: Vw_min = lowest wheel VCC during the interruption.
* Pass: Vw_min stays above 1.65 V (TXE8124-Q1 minimum VCC) for the interruption
*       length you decide to tolerate. Below 1.35 V the chip may reset; between
*       1.05 and 1.65 V it may lose configuration without a clean reset.
* Simplified 2026-09-30 (v3): harness inductance and the separate ground return
*   removed. Ride-through is a millisecond effect set by C x dV = I x t; the
*   2 uH harness inductance only matters over microseconds (tests 1.1-1.4 cover
*   those). The floating wheel-ground node that the inductors created is what
*   LTSpice kept reporting as a singular matrix (nodes vw, then gw).
*   Supply and return harness resistance are lumped into Rh (0.2 Ohm total).
* ngspice reference (v3, same as the earlier version): 1 ms at 100 mA -> 0.16 V
*   with 10 uF (collapse), 2.99 V with 330 uF. LEDs off: > 3.2 V either way.
V33 dash 0 3.3
Sqd dash a ctl 0 SWqd
.model SWqd SW(Ron=0.05 Roff=100Meg Vt=1.65 Vh=0)
Vctl ctl 0 PWL(0 3.3 10m 3.3 {10m+1u} 0 {10m+Tdrop} 0 {10m+Tdrop+1u} 3.3 40m 3.3)
Rh a vw 0.2
Cw1 vw e {Cbulk}
Resr e 0 5m
Cw2 vw 0 100n
Rload vw 0 {3.3/Ild}
.step param Ild list 1m 100m
.step param Cbulk list 10u 330u
.step param Tdrop list 100u 1m
.tran 10u 40m 0 1u
.meas TRAN Vw_min MIN V(vw)
.end
