* Test 4 wheel short - Step 1 short at the wheel end
* Plan: ltspice-testing/qd_supply_hotplug_fault_test_plan.md step 4
* Belongs to the DASH schematic. Only meaningful once a limiter part is chosen:
*   replace B1 with the vendor eFuse / current-limited switch model then.
* The Dash 3.3 V regulator (node g) feeds the Dash's own logic load AND a
* current-limited branch to the wheel. The wheel input shorts to GND at 10 ms
* for 20 ms, after the wheel has powered up from empty (uic) by ~5 ms (e.g. a QD pin to chassis during a gloved disconnect).
* Record per step: Vdash_min (Dash logic rail), I_qd_max (current through the
*   QD/harness), I_short_max (current in the short itself, incl. the wheel bulk
*   cap dumping into it - local to the wheel, does not cross the QD; with a
*   10 mOhm ideal short this reads 100+ A, a real short has more resistance).
* Pass: Vdash_min stays within the Dash logic rail's tolerance (e.g. >= 3.13 V
*   for -5 %), and I_qd_max stays under the QD contact and harness rating.
* ngspice reference (2026-09-28): QD current held at Ilim (+~10 % while the limiter
*   settles); Dash rail dips to 3.25-3.28 V with the placeholder 0.05 Ohm source.
* Checked in ngspice by expanding .step; not yet opened in LTSpice.
Vreg reg 0 3.3
Rsrc reg g 0.05
Rdash g 0 33
* Dash rail decoupling (placeholder)
Cdash g 0 10u
B1 g a I=min(max(V(g,a)/0.01,0),Ilim)
Rb g a 1Meg
* Limiter output Schottky and capacitance, as in test 1 step 6
Dfw 0 a Dschottky
.model Dschottky D(Is=1u Rs=0.05 N=1.05 Cjo=100p)
Cq a 0 1n
Lh a b 2u
Rh b c 0.1
Cin c e {Cbulk}
Resr e 0 5m
Rload c 0 1k
Vss c s 0
Ssh s 0 ctl 0 SWs
.model SWs SW(Ron=10m Roff=100Meg Vt=0.5 Vh=0)
Vctl ctl 0 PULSE(0 1 10m 1u 1u 20m 1)
.step param Ilim list 0.25 0.5 1
.step param Cbulk list 10u 330u
.tran 10u 50m 0 1u uic
.meas TRAN Vdash_min MIN V(g) FROM=9m TO=31m
.meas TRAN I_qd_max MAX I(Lh) FROM=9m TO=31m
.meas TRAN I_short_max MAX I(Vss)
.end
