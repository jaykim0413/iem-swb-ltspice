* SWB rotary channels - 24 lines on Chip 1, two knobs, shared ground return
* Knob 1 parked on position 3, knob 2 parked on position 7.
* Rshared is swept as a behavioral resistor: ohms = volts on node ctl.
.param Rpu=70k
.param Rsel=0.1
.param Ropen=1G
.param Rret=0.1
V1 VCC 0 3.3
Vsweep ctl 0 0

* ---- Knob 1, positions 1-12, closed on position 3 ----
RA1 VCC A1 {Rpu}
RCA1 A1 COM1 {Ropen}
RA2 VCC A2 {Rpu}
RCA2 A2 COM1 {Ropen}
RA3 VCC A3 {Rpu}
RCA3 A3 COM1 {Rsel}
RA4 VCC A4 {Rpu}
RCA4 A4 COM1 {Ropen}
RA5 VCC A5 {Rpu}
RCA5 A5 COM1 {Ropen}
RA6 VCC A6 {Rpu}
RCA6 A6 COM1 {Ropen}
RA7 VCC A7 {Rpu}
RCA7 A7 COM1 {Ropen}
RA8 VCC A8 {Rpu}
RCA8 A8 COM1 {Ropen}
RA9 VCC A9 {Rpu}
RCA9 A9 COM1 {Ropen}
RA10 VCC A10 {Rpu}
RCA10 A10 COM1 {Ropen}
RA11 VCC A11 {Rpu}
RCA11 A11 COM1 {Ropen}
RA12 VCC A12 {Rpu}
RCA12 A12 COM1 {Ropen}

* ---- Knob 2, positions 1-12, closed on position 7 ----
RB1 VCC B1 {Rpu}
RCB1 B1 COM2 {Ropen}
RB2 VCC B2 {Rpu}
RCB2 B2 COM2 {Ropen}
RB3 VCC B3 {Rpu}
RCB3 B3 COM2 {Ropen}
RB4 VCC B4 {Rpu}
RCB4 B4 COM2 {Ropen}
RB5 VCC B5 {Rpu}
RCB5 B5 COM2 {Ropen}
RB6 VCC B6 {Rpu}
RCB6 B6 COM2 {Ropen}
RB7 VCC B7 {Rpu}
RCB7 B7 COM2 {Rsel}
RB8 VCC B8 {Rpu}
RCB8 B8 COM2 {Ropen}
RB9 VCC B9 {Rpu}
RCB9 B9 COM2 {Ropen}
RB10 VCC B10 {Rpu}
RCB10 B10 COM2 {Ropen}
RB11 VCC B11 {Rpu}
RCB11 B11 COM2 {Ropen}
RB12 VCC B12 {Rpu}
RCB12 B12 COM2 {Ropen}

* ---- Return path: each knob's common, then the shared segment ----
RR1 COM1 GNDW {Rret}
RR2 COM2 GNDW {Rret}
RSH GNDW 0 R={V(ctl)}

.dc Vsweep 1m 100k 50
.meas DC R_shared_fail FIND V(ctl) WHEN V(A3)=0.99
.meas DC V_open_at_fail FIND V(A1) WHEN V(A3)=0.99
.meas DC V_knob2_at_fail FIND V(B7) WHEN V(A3)=0.99
.meas DC I_total FIND I(V1) AT=1m
.end
