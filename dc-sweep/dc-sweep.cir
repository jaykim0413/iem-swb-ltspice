* SWB rotary line - DC corner + contact-degradation sweep
V1 VCC 0 3.3
R1 VCC IN {Rpu}
R2 IN 0 {Rc}
.step param Rpu list 70k 100k 140k
.step param Rc 0 200k 2k
.op
.meas V_IN  FIND V(IN)
.meas I_wet FIND I(R1)
.end
